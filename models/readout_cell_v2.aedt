# Ansys Electronics Desktop project, version 2026.1
materials:
  vacuum: permittivity=1
  pec: conductivity=1e+30
  silicon: permittivity=11.9 permeability=1
surface materials:
  Steel-oxidised-surface

design W200_Eigen (HFSS, Eigenmode, model units mm)
variables:
  Lj = 16nH
geometry:
  layer_1_datatype_0_plane [pec] = polyline(z=0.0001mm, xy in mm: (-2.5, -2) (2.5, -2) (2.5, 2) (-2.5, 2) (-2.5, -2), closed, covered)
  layer_1_datatype_0_plane.thicken(0.0002mm, both sides)
  layer_3_datatype_0_plane [silicon] = polyline(z=-0.25mm, xy in mm: (-2.5, -2) (2.5, -2) (2.5, 2) (-2.5, 2) (-2.5, -2), closed, covered)
  layer_3_datatype_0_plane.thicken(-0.5mm, both sides)
  vacuum_box [vacuum] = polyline(z=0mm, xy in mm: (-2.5, -2) (2.5, -2) (2.5, 2) (-2.5, 2) (-2.5, -2), closed, covered)
  vacuum_box.thicken(3mm, both sides)
  readout_wire_Q1 = polyline(z=0.0001mm, xy in mm: (-0.93, -0.5875) (-0.93, -0.5625) (-0.995, -0.48) (-0.995, -0.375))
  readout_wire_Q1_shortline [pec] = polyline((-0.935mm, -0.5875mm, 0.0001mm) (-0.925mm, -0.5875mm, 0.0001mm))
  readout_wire_Q1_shortline.sweep_along_path(readout_wire_Q1)
  readout_wire_Q1_shortline.thicken(0.0002mm, both sides)
  readout_wire_sub_Q1 = polyline(z=0.0001mm, xy in mm: (-0.93, -0.5875) (-0.93, -0.5625) (-0.995, -0.48) (-0.995, -0.375))
  readout_wire_sub_Q1_shortline = polyline((-0.941mm, -0.5875mm, 0.0001mm) (-0.919mm, -0.5875mm, 0.0001mm))
  readout_wire_sub_Q1_shortline.sweep_along_path(readout_wire_sub_Q1)
  readout_wire_sub_Q1_shortline.thicken(0.0002mm, both sides)
  prime_cpw_Tee = polyline((-0.25mm, 1mm, 0.0001mm) (0.25mm, 1mm, 0.0001mm))
  prime_cpw_Tee_shortline [pec] = polyline((-0.25mm, 1.005mm, 0.0001mm) (-0.25mm, 0.995mm, 0.0001mm))
  prime_cpw_Tee_shortline.sweep_along_path(prime_cpw_Tee)
  prime_cpw_Tee_shortline.thicken(0.0002mm, both sides)
  prime_cpw_sub_Tee = polyline((-0.25mm, 1mm, 0.0001mm) (0.25mm, 1mm, 0.0001mm))
  prime_cpw_sub_Tee_shortline = polyline((-0.25mm, 1.011mm, 0.0001mm) (-0.25mm, 0.989mm, 0.0001mm))
  prime_cpw_sub_Tee_shortline.sweep_along_path(prime_cpw_sub_Tee)
  prime_cpw_sub_Tee_shortline.thicken(0.0002mm, both sides)
  second_cpw_Tee = polyline(z=0.0001mm, xy in mm: (-0.125, 0.973) (0.125, 0.973) (0.125, 0.873))
  second_cpw_Tee.fillet(Vertices=second_cpw_Tee.vertex(at (0.125, 0.973, 0.0001)) Radius=0.025mm Setback=0mm)
  second_cpw_Tee_shortline [pec] = polyline((-0.125mm, 0.978mm, 0.0001mm) (-0.125mm, 0.968mm, 0.0001mm))
  second_cpw_Tee_shortline.sweep_along_path(second_cpw_Tee)
  second_cpw_Tee_shortline.thicken(0.0002mm, both sides)
  second_cpw_sub_Tee = polyline(z=0.0001mm, xy in mm: (-0.125, 0.973) (0.125, 0.973) (0.125, 0.873))
  second_cpw_sub_Tee.fillet(Vertices=second_cpw_sub_Tee.vertex(at (0.125, 0.973, 0.0001)) Radius=0.025mm Setback=0mm)
  second_cpw_sub_Tee_shortline = polyline((-0.125mm, 0.984mm, 0.0001mm) (-0.125mm, 0.962mm, 0.0001mm))
  second_cpw_sub_Tee_shortline.sweep_along_path(second_cpw_sub_Tee)
  second_cpw_sub_Tee_shortline.thicken(0.0002mm, both sides)
  trace_FeedLeft = polyline((-1.975mm, 1mm, 0.0001mm) (-0.25mm, 1mm, 0.0001mm))
  trace_FeedLeft_shortline [pec] = polyline((-1.975mm, 1.005mm, 0.0001mm) (-1.975mm, 0.995mm, 0.0001mm))
  trace_FeedLeft_shortline.sweep_along_path(trace_FeedLeft)
  trace_FeedLeft_shortline.thicken(0.0002mm, both sides)
  cut_FeedLeft = polyline((-1.975mm, 1mm, 0.0001mm) (-0.25mm, 1mm, 0.0001mm))
  cut_FeedLeft_shortline = polyline((-1.975mm, 1.011mm, 0.0001mm) (-1.975mm, 0.989mm, 0.0001mm))
  cut_FeedLeft_shortline.sweep_along_path(cut_FeedLeft)
  cut_FeedLeft_shortline.thicken(0.0002mm, both sides)
  trace_FeedRight = polyline((0.25mm, 1mm, 0.0001mm) (1.975mm, 1mm, 0.0001mm))
  trace_FeedRight_shortline [pec] = polyline((0.25mm, 1.005mm, 0.0001mm) (0.25mm, 0.995mm, 0.0001mm))
  trace_FeedRight_shortline.sweep_along_path(trace_FeedRight)
  trace_FeedRight_shortline.thicken(0.0002mm, both sides)
  cut_FeedRight = polyline((0.25mm, 1mm, 0.0001mm) (1.975mm, 1mm, 0.0001mm))
  cut_FeedRight_shortline = polyline((0.25mm, 1.011mm, 0.0001mm) (0.25mm, 0.989mm, 0.0001mm))
  cut_FeedRight_shortline.sweep_along_path(cut_FeedRight)
  cut_FeedRight_shortline.thicken(0.0002mm, both sides)
  trace_Readout = polyline(z=0.0001mm, xy in mm: (-0.995, -0.375) (-0.995, -0.06324778) (-0.845, -0.06324778) (-0.845, -0.38675222) (-0.695, -0.38675222) (-0.695, -0.06324778) (-0.545, -0.06324778) (-0.545, -0.38675222) (-0.395, -0.38675222) (-0.395, -0.06324778) (-0.245, -0.06324778) (-0.245, -0.38675222) (0.125, -0.38675222) (0.125, 0.873))
  trace_Readout.fillet(Vertices=trace_Readout.vertex(at (-0.995, -0.0632478, 0.0001)) Radius=0.06mm Setback=0mm)
  trace_Readout.fillet(Vertices=trace_Readout.vertex(at (-0.845, -0.0632478, 0.0001)) Radius=0.06mm Setback=0mm)
  trace_Readout.fillet(Vertices=trace_Readout.vertex(at (-0.845, -0.386752, 0.0001)) Radius=0.06mm Setback=0mm)
  trace_Readout.fillet(Vertices=trace_Readout.vertex(at (-0.695, -0.386752, 0.0001)) Radius=0.06mm Setback=0mm)
  trace_Readout.fillet(Vertices=trace_Readout.vertex(at (-0.695, -0.0632478, 0.0001)) Radius=0.06mm Setback=0mm)
  trace_Readout.fillet(Vertices=trace_Readout.vertex(at (-0.545, -0.0632478, 0.0001)) Radius=0.06mm Setback=0mm)
  trace_Readout.fillet(Vertices=trace_Readout.vertex(at (-0.545, -0.386752, 0.0001)) Radius=0.06mm Setback=0mm)
  trace_Readout.fillet(Vertices=trace_Readout.vertex(at (-0.395, -0.386752, 0.0001)) Radius=0.06mm Setback=0mm)
  trace_Readout.fillet(Vertices=trace_Readout.vertex(at (-0.395, -0.0632478, 0.0001)) Radius=0.06mm Setback=0mm)
  trace_Readout.fillet(Vertices=trace_Readout.vertex(at (-0.245, -0.0632478, 0.0001)) Radius=0.06mm Setback=0mm)
  trace_Readout.fillet(Vertices=trace_Readout.vertex(at (-0.245, -0.386752, 0.0001)) Radius=0.06mm Setback=0mm)
  trace_Readout.fillet(Vertices=trace_Readout.vertex(at (0.125, -0.386752, 0.0001)) Radius=0.06mm Setback=0mm)
  trace_Readout_shortline [pec] = polyline((-1mm, -0.375mm, 0.0001mm) (-0.99mm, -0.375mm, 0.0001mm))
  trace_Readout_shortline.sweep_along_path(trace_Readout)
  trace_Readout_shortline.thicken(0.0002mm, both sides)
  cut_Readout = polyline(z=0.0001mm, xy in mm: (-0.995, -0.375) (-0.995, -0.06324778) (-0.845, -0.06324778) (-0.845, -0.38675222) (-0.695, -0.38675222) (-0.695, -0.06324778) (-0.545, -0.06324778) (-0.545, -0.38675222) (-0.395, -0.38675222) (-0.395, -0.06324778) (-0.245, -0.06324778) (-0.245, -0.38675222) (0.125, -0.38675222) (0.125, 0.873))
  cut_Readout.fillet(Vertices=cut_Readout.vertex(at (-0.995, -0.0632478, 0.0001)) Radius=0.06mm Setback=0mm)
  cut_Readout.fillet(Vertices=cut_Readout.vertex(at (-0.845, -0.0632478, 0.0001)) Radius=0.06mm Setback=0mm)
  cut_Readout.fillet(Vertices=cut_Readout.vertex(at (-0.845, -0.386752, 0.0001)) Radius=0.06mm Setback=0mm)
  cut_Readout.fillet(Vertices=cut_Readout.vertex(at (-0.695, -0.386752, 0.0001)) Radius=0.06mm Setback=0mm)
  cut_Readout.fillet(Vertices=cut_Readout.vertex(at (-0.695, -0.0632478, 0.0001)) Radius=0.06mm Setback=0mm)
  cut_Readout.fillet(Vertices=cut_Readout.vertex(at (-0.545, -0.0632478, 0.0001)) Radius=0.06mm Setback=0mm)
  cut_Readout.fillet(Vertices=cut_Readout.vertex(at (-0.545, -0.386752, 0.0001)) Radius=0.06mm Setback=0mm)
  cut_Readout.fillet(Vertices=cut_Readout.vertex(at (-0.395, -0.386752, 0.0001)) Radius=0.06mm Setback=0mm)
  cut_Readout.fillet(Vertices=cut_Readout.vertex(at (-0.395, -0.0632478, 0.0001)) Radius=0.06mm Setback=0mm)
  cut_Readout.fillet(Vertices=cut_Readout.vertex(at (-0.245, -0.0632478, 0.0001)) Radius=0.06mm Setback=0mm)
  cut_Readout.fillet(Vertices=cut_Readout.vertex(at (-0.245, -0.386752, 0.0001)) Radius=0.06mm Setback=0mm)
  cut_Readout.fillet(Vertices=cut_Readout.vertex(at (0.125, -0.386752, 0.0001)) Radius=0.06mm Setback=0mm)
  cut_Readout_shortline = polyline((-1.006mm, -0.375mm, 0.0001mm) (-0.984mm, -0.375mm, 0.0001mm))
  cut_Readout_shortline.sweep_along_path(cut_Readout)
  cut_Readout_shortline.thicken(0.0002mm, both sides)
  pad_top_Q1 [pec] = polyline(z=0.0001mm, xy in mm: (-0.815, -1.0125) (-0.815, -0.5875) (-0.905, -0.5875) (-0.905, -1.0125) (-0.815, -1.0125), closed, covered)
  pad_top_Q1.thicken(0.0002mm, both sides)
  pad_bot_Q1 [pec] = polyline(z=0.0001mm, xy in mm: (-0.695, -1.0125) (-0.695, -0.5875) (-0.785, -0.5875) (-0.785, -1.0125) (-0.695, -1.0125), closed, covered)
  pad_bot_Q1.thicken(0.0002mm, both sides)
  rect_pk_Q1 = polyline(z=0.0001mm, xy in mm: (-0.475, -1.125) (-0.475, -0.475) (-1.125, -0.475) (-1.125, -1.125) (-0.475, -1.125), closed, covered)
  rect_pk_Q1.thicken(0.0002mm, both sides)
  readout_connector_pad_Q1 [pec] = polyline(z=0.0001mm, xy in mm: (-0.92, -0.7875) (-0.92, -0.5875) (-0.95, -0.5875) (-0.95, -0.7875) (-0.92, -0.7875), closed, covered)
  readout_connector_pad_Q1.thicken(0.0002mm, both sides)
  launch_pad_P1 [pec] = polyline(z=0.0001mm, xy in mm: (-2, 1.005) (-2.122, 1.04) (-2.202, 1.04) (-2.202, 0.96) (-2.122, 0.96) (-2, 0.995) (-1.975, 0.995) (-1.975, 1.005) (-2, 1.005), closed, covered)
  launch_pad_P1.thicken(0.0002mm, both sides)
  pocket_P1 = polyline(z=0.0001mm, xy in mm: (-2, 1.011) (-2.122, 1.098) (-2.26, 1.098) (-2.26, 0.902) (-2.122, 0.902) (-2, 0.989) (-1.975, 0.989) (-1.975, 1.011) (-2, 1.011), closed, covered)
  pocket_P1.thicken(0.0002mm, both sides)
  launch_pad_P2 [pec] = polyline(z=0.0001mm, xy in mm: (2, 0.995) (2.122, 0.96) (2.202, 0.96) (2.202, 1.04) (2.122, 1.04) (2, 1.005) (1.975, 1.005) (1.975, 0.995) (2, 0.995), closed, covered)
  launch_pad_P2.thicken(0.0002mm, both sides)
  pocket_P2 = polyline(z=0.0001mm, xy in mm: (2, 0.989) (2.122, 0.902) (2.26, 0.902) (2.26, 1.098) (2.122, 1.098) (2, 1.011) (1.975, 1.011) (1.975, 0.989) (2, 0.989), closed, covered)
  pocket_P2.thicken(0.0002mm, both sides)
  JJ_Lj_1_rect_jj_ = polyline((-0.785mm, -0.8mm, 0.0001mm) (-0.815mm, -0.8mm, 0.0001mm))
  JJ_rect_Lj_1_rect_jj = polyline((-0.785mm, -0.8mm, 0.0001mm) (-0.815mm, -0.8mm, 0.0001mm), section line width=0.02mm)
  endcap_P1_in_1 = polyline((-2.26mm, 1mm, 0.0001mm) (-2.202mm, 1mm, 0.0001mm), section line width=0.196mm)
  endcap_P1_in_1.thicken(0.0002mm, both sides)
  endcap_P2_in_1 = polyline((2.26mm, 1mm, 0.0001mm) (2.202mm, 1mm, 0.0001mm), section line width=0.196mm)
  endcap_P2_in_1.thicken(0.0002mm, both sides)
  layer_1_datatype_0_plane.subtract(readout_wire_sub_Q1_shortline, prime_cpw_sub_Tee_shortline, second_cpw_sub_Tee_shortline, cut_FeedLeft_shortline, cut_FeedRight_shortline, cut_Readout_shortline, rect_pk_Q1, pocket_P1, pocket_P2, endcap_P1_in_1, endcap_P2_in_1)
boundaries and excitations:
  rlc_JJ_rect_Lj_1_rect_jj: Lumped RLC Objects=JJ_rect_Lj_1_rect_jj CurrentLine{(-0.785, -0.8, 0.0001) -> (-0.815, -0.8, 0.0001)} RLC_Type=Parallel Inductance=Lj
mesh:
  JunctionMesh: LengthBased Objects=JJ_rect_Lj_1_rect_jj MaxLength=5um
setups:
  EigenSetup: HfssEigen MinimumFrequency=2GHz NumModes=2 MaxDeltaFreq=0.3 ConvergeOnRealFreq=false MaximumPasses=16 MinimumPasses=3 MinimumConvergedPasses=2 PercentRefinement=25 BasisOrder=1
source amplitudes:
  #-10:1: 0 0
  #-10:2: 1 0
reports:
  Freq. vs. pass: re(Mode(1)), re(Mode(2)) vs Pass on EigenSetup : AdaptivePass [Lj=16nH]

design W200_Driven (HFSS, HFSS Modal Network, model units mm)
variables:
  Lj = 16nH
geometry:
  layer_1_datatype_0_plane [pec] = polyline(z=0.0001mm, xy in mm: (-2.5, -2) (2.5, -2) (2.5, 2) (-2.5, 2) (-2.5, -2), closed, covered)
  layer_1_datatype_0_plane.thicken(0.0002mm, both sides)
  layer_3_datatype_0_plane [silicon] = polyline(z=-0.25mm, xy in mm: (-2.5, -2) (2.5, -2) (2.5, 2) (-2.5, 2) (-2.5, -2), closed, covered)
  layer_3_datatype_0_plane.thicken(-0.5mm, both sides)
  vacuum_box [vacuum] = polyline(z=0mm, xy in mm: (-2.5, -2) (2.5, -2) (2.5, 2) (-2.5, 2) (-2.5, -2), closed, covered)
  vacuum_box.thicken(3mm, both sides)
  readout_wire_Q1 = polyline(z=0.0001mm, xy in mm: (-0.93, -0.5875) (-0.93, -0.5625) (-0.995, -0.48) (-0.995, -0.375))
  readout_wire_Q1_shortline [pec] = polyline((-0.935mm, -0.5875mm, 0.0001mm) (-0.925mm, -0.5875mm, 0.0001mm))
  readout_wire_Q1_shortline.sweep_along_path(readout_wire_Q1)
  readout_wire_Q1_shortline.thicken(0.0002mm, both sides)
  readout_wire_sub_Q1 = polyline(z=0.0001mm, xy in mm: (-0.93, -0.5875) (-0.93, -0.5625) (-0.995, -0.48) (-0.995, -0.375))
  readout_wire_sub_Q1_shortline = polyline((-0.941mm, -0.5875mm, 0.0001mm) (-0.919mm, -0.5875mm, 0.0001mm))
  readout_wire_sub_Q1_shortline.sweep_along_path(readout_wire_sub_Q1)
  readout_wire_sub_Q1_shortline.thicken(0.0002mm, both sides)
  prime_cpw_Tee = polyline((-0.25mm, 1mm, 0.0001mm) (0.25mm, 1mm, 0.0001mm))
  prime_cpw_Tee_shortline [pec] = polyline((-0.25mm, 1.005mm, 0.0001mm) (-0.25mm, 0.995mm, 0.0001mm))
  prime_cpw_Tee_shortline.sweep_along_path(prime_cpw_Tee)
  prime_cpw_Tee_shortline.thicken(0.0002mm, both sides)
  prime_cpw_sub_Tee = polyline((-0.25mm, 1mm, 0.0001mm) (0.25mm, 1mm, 0.0001mm))
  prime_cpw_sub_Tee_shortline = polyline((-0.25mm, 1.011mm, 0.0001mm) (-0.25mm, 0.989mm, 0.0001mm))
  prime_cpw_sub_Tee_shortline.sweep_along_path(prime_cpw_sub_Tee)
  prime_cpw_sub_Tee_shortline.thicken(0.0002mm, both sides)
  second_cpw_Tee = polyline(z=0.0001mm, xy in mm: (-0.125, 0.973) (0.125, 0.973) (0.125, 0.873))
  second_cpw_Tee.fillet(Vertices=second_cpw_Tee.vertex(at (0.125, 0.973, 0.0001)) Radius=0.025mm Setback=0mm)
  second_cpw_Tee_shortline [pec] = polyline((-0.125mm, 0.978mm, 0.0001mm) (-0.125mm, 0.968mm, 0.0001mm))
  second_cpw_Tee_shortline.sweep_along_path(second_cpw_Tee)
  second_cpw_Tee_shortline.thicken(0.0002mm, both sides)
  second_cpw_sub_Tee = polyline(z=0.0001mm, xy in mm: (-0.125, 0.973) (0.125, 0.973) (0.125, 0.873))
  second_cpw_sub_Tee.fillet(Vertices=second_cpw_sub_Tee.vertex(at (0.125, 0.973, 0.0001)) Radius=0.025mm Setback=0mm)
  second_cpw_sub_Tee_shortline = polyline((-0.125mm, 0.984mm, 0.0001mm) (-0.125mm, 0.962mm, 0.0001mm))
  second_cpw_sub_Tee_shortline.sweep_along_path(second_cpw_sub_Tee)
  second_cpw_sub_Tee_shortline.thicken(0.0002mm, both sides)
  trace_FeedLeft = polyline((-1.975mm, 1mm, 0.0001mm) (-0.25mm, 1mm, 0.0001mm))
  trace_FeedLeft_shortline [pec] = polyline((-1.975mm, 1.005mm, 0.0001mm) (-1.975mm, 0.995mm, 0.0001mm))
  trace_FeedLeft_shortline.sweep_along_path(trace_FeedLeft)
  trace_FeedLeft_shortline.thicken(0.0002mm, both sides)
  cut_FeedLeft = polyline((-1.975mm, 1mm, 0.0001mm) (-0.25mm, 1mm, 0.0001mm))
  cut_FeedLeft_shortline = polyline((-1.975mm, 1.011mm, 0.0001mm) (-1.975mm, 0.989mm, 0.0001mm))
  cut_FeedLeft_shortline.sweep_along_path(cut_FeedLeft)
  cut_FeedLeft_shortline.thicken(0.0002mm, both sides)
  trace_FeedRight = polyline((0.25mm, 1mm, 0.0001mm) (1.975mm, 1mm, 0.0001mm))
  trace_FeedRight_shortline [pec] = polyline((0.25mm, 1.005mm, 0.0001mm) (0.25mm, 0.995mm, 0.0001mm))
  trace_FeedRight_shortline.sweep_along_path(trace_FeedRight)
  trace_FeedRight_shortline.thicken(0.0002mm, both sides)
  cut_FeedRight = polyline((0.25mm, 1mm, 0.0001mm) (1.975mm, 1mm, 0.0001mm))
  cut_FeedRight_shortline = polyline((0.25mm, 1.011mm, 0.0001mm) (0.25mm, 0.989mm, 0.0001mm))
  cut_FeedRight_shortline.sweep_along_path(cut_FeedRight)
  cut_FeedRight_shortline.thicken(0.0002mm, both sides)
  trace_Readout = polyline(z=0.0001mm, xy in mm: (-0.995, -0.375) (-0.995, -0.06324778) (-0.845, -0.06324778) (-0.845, -0.38675222) (-0.695, -0.38675222) (-0.695, -0.06324778) (-0.545, -0.06324778) (-0.545, -0.38675222) (-0.395, -0.38675222) (-0.395, -0.06324778) (-0.245, -0.06324778) (-0.245, -0.38675222) (0.125, -0.38675222) (0.125, 0.873))
  trace_Readout.fillet(Vertices=trace_Readout.vertex(at (-0.995, -0.0632478, 0.0001)) Radius=0.06mm Setback=0mm)
  trace_Readout.fillet(Vertices=trace_Readout.vertex(at (-0.845, -0.0632478, 0.0001)) Radius=0.06mm Setback=0mm)
  trace_Readout.fillet(Vertices=trace_Readout.vertex(at (-0.845, -0.386752, 0.0001)) Radius=0.06mm Setback=0mm)
  trace_Readout.fillet(Vertices=trace_Readout.vertex(at (-0.695, -0.386752, 0.0001)) Radius=0.06mm Setback=0mm)
  trace_Readout.fillet(Vertices=trace_Readout.vertex(at (-0.695, -0.0632478, 0.0001)) Radius=0.06mm Setback=0mm)
  trace_Readout.fillet(Vertices=trace_Readout.vertex(at (-0.545, -0.0632478, 0.0001)) Radius=0.06mm Setback=0mm)
  trace_Readout.fillet(Vertices=trace_Readout.vertex(at (-0.545, -0.386752, 0.0001)) Radius=0.06mm Setback=0mm)
  trace_Readout.fillet(Vertices=trace_Readout.vertex(at (-0.395, -0.386752, 0.0001)) Radius=0.06mm Setback=0mm)
  trace_Readout.fillet(Vertices=trace_Readout.vertex(at (-0.395, -0.0632478, 0.0001)) Radius=0.06mm Setback=0mm)
  trace_Readout.fillet(Vertices=trace_Readout.vertex(at (-0.245, -0.0632478, 0.0001)) Radius=0.06mm Setback=0mm)
  trace_Readout.fillet(Vertices=trace_Readout.vertex(at (-0.245, -0.386752, 0.0001)) Radius=0.06mm Setback=0mm)
  trace_Readout.fillet(Vertices=trace_Readout.vertex(at (0.125, -0.386752, 0.0001)) Radius=0.06mm Setback=0mm)
  trace_Readout_shortline [pec] = polyline((-1mm, -0.375mm, 0.0001mm) (-0.99mm, -0.375mm, 0.0001mm))
  trace_Readout_shortline.sweep_along_path(trace_Readout)
  trace_Readout_shortline.thicken(0.0002mm, both sides)
  cut_Readout = polyline(z=0.0001mm, xy in mm: (-0.995, -0.375) (-0.995, -0.06324778) (-0.845, -0.06324778) (-0.845, -0.38675222) (-0.695, -0.38675222) (-0.695, -0.06324778) (-0.545, -0.06324778) (-0.545, -0.38675222) (-0.395, -0.38675222) (-0.395, -0.06324778) (-0.245, -0.06324778) (-0.245, -0.38675222) (0.125, -0.38675222) (0.125, 0.873))
  cut_Readout.fillet(Vertices=cut_Readout.vertex(at (-0.995, -0.0632478, 0.0001)) Radius=0.06mm Setback=0mm)
  cut_Readout.fillet(Vertices=cut_Readout.vertex(at (-0.845, -0.0632478, 0.0001)) Radius=0.06mm Setback=0mm)
  cut_Readout.fillet(Vertices=cut_Readout.vertex(at (-0.845, -0.386752, 0.0001)) Radius=0.06mm Setback=0mm)
  cut_Readout.fillet(Vertices=cut_Readout.vertex(at (-0.695, -0.386752, 0.0001)) Radius=0.06mm Setback=0mm)
  cut_Readout.fillet(Vertices=cut_Readout.vertex(at (-0.695, -0.0632478, 0.0001)) Radius=0.06mm Setback=0mm)
  cut_Readout.fillet(Vertices=cut_Readout.vertex(at (-0.545, -0.0632478, 0.0001)) Radius=0.06mm Setback=0mm)
  cut_Readout.fillet(Vertices=cut_Readout.vertex(at (-0.545, -0.386752, 0.0001)) Radius=0.06mm Setback=0mm)
  cut_Readout.fillet(Vertices=cut_Readout.vertex(at (-0.395, -0.386752, 0.0001)) Radius=0.06mm Setback=0mm)
  cut_Readout.fillet(Vertices=cut_Readout.vertex(at (-0.395, -0.0632478, 0.0001)) Radius=0.06mm Setback=0mm)
  cut_Readout.fillet(Vertices=cut_Readout.vertex(at (-0.245, -0.0632478, 0.0001)) Radius=0.06mm Setback=0mm)
  cut_Readout.fillet(Vertices=cut_Readout.vertex(at (-0.245, -0.386752, 0.0001)) Radius=0.06mm Setback=0mm)
  cut_Readout.fillet(Vertices=cut_Readout.vertex(at (0.125, -0.386752, 0.0001)) Radius=0.06mm Setback=0mm)
  cut_Readout_shortline = polyline((-1.006mm, -0.375mm, 0.0001mm) (-0.984mm, -0.375mm, 0.0001mm))
  cut_Readout_shortline.sweep_along_path(cut_Readout)
  cut_Readout_shortline.thicken(0.0002mm, both sides)
  pad_top_Q1 [pec] = polyline(z=0.0001mm, xy in mm: (-0.815, -1.0125) (-0.815, -0.5875) (-0.905, -0.5875) (-0.905, -1.0125) (-0.815, -1.0125), closed, covered)
  pad_top_Q1.thicken(0.0002mm, both sides)
  pad_bot_Q1 [pec] = polyline(z=0.0001mm, xy in mm: (-0.695, -1.0125) (-0.695, -0.5875) (-0.785, -0.5875) (-0.785, -1.0125) (-0.695, -1.0125), closed, covered)
  pad_bot_Q1.thicken(0.0002mm, both sides)
  rect_pk_Q1 = polyline(z=0.0001mm, xy in mm: (-0.475, -1.125) (-0.475, -0.475) (-1.125, -0.475) (-1.125, -1.125) (-0.475, -1.125), closed, covered)
  rect_pk_Q1.thicken(0.0002mm, both sides)
  readout_connector_pad_Q1 [pec] = polyline(z=0.0001mm, xy in mm: (-0.92, -0.7875) (-0.92, -0.5875) (-0.95, -0.5875) (-0.95, -0.7875) (-0.92, -0.7875), closed, covered)
  readout_connector_pad_Q1.thicken(0.0002mm, both sides)
  launch_pad_P1 [pec] = polyline(z=0.0001mm, xy in mm: (-2, 1.005) (-2.122, 1.04) (-2.202, 1.04) (-2.202, 0.96) (-2.122, 0.96) (-2, 0.995) (-1.975, 0.995) (-1.975, 1.005) (-2, 1.005), closed, covered)
  launch_pad_P1.thicken(0.0002mm, both sides)
  pocket_P1 = polyline(z=0.0001mm, xy in mm: (-2, 1.011) (-2.122, 1.098) (-2.26, 1.098) (-2.26, 0.902) (-2.122, 0.902) (-2, 0.989) (-1.975, 0.989) (-1.975, 1.011) (-2, 1.011), closed, covered)
  pocket_P1.thicken(0.0002mm, both sides)
  launch_pad_P2 [pec] = polyline(z=0.0001mm, xy in mm: (2, 0.995) (2.122, 0.96) (2.202, 0.96) (2.202, 1.04) (2.122, 1.04) (2, 1.005) (1.975, 1.005) (1.975, 0.995) (2, 0.995), closed, covered)
  launch_pad_P2.thicken(0.0002mm, both sides)
  pocket_P2 = polyline(z=0.0001mm, xy in mm: (2, 0.989) (2.122, 0.902) (2.26, 0.902) (2.26, 1.098) (2.122, 1.098) (2, 1.011) (1.975, 1.011) (1.975, 0.989) (2, 0.989), closed, covered)
  pocket_P2.thicken(0.0002mm, both sides)
  JJ_Lj_1_rect_jj_ = polyline((-0.785mm, -0.8mm, 0.0001mm) (-0.815mm, -0.8mm, 0.0001mm))
  JJ_rect_Lj_1_rect_jj = polyline((-0.785mm, -0.8mm, 0.0001mm) (-0.815mm, -0.8mm, 0.0001mm), section line width=0.02mm)
  port_endcap_P1_in_1 = polyline((-2.26mm, 1mm, 0.0001mm) (-2.202mm, 1mm, 0.0001mm), section line width=0.196mm)
  port_endcap_P1_in_1.thicken(0.0002mm, both sides)
  port_endcap_P2_in_1 = polyline((2.26mm, 1mm, 0.0001mm) (2.202mm, 1mm, 0.0001mm), section line width=0.196mm)
  port_endcap_P2_in_1.thicken(0.0002mm, both sides)
  Port_P1_in = polyline((-2.26mm, 1mm, 0.0001mm) (-2.202mm, 1mm, 0.0001mm), section line width=0.08mm)
  Port_P2_in = polyline((2.26mm, 1mm, 0.0001mm) (2.202mm, 1mm, 0.0001mm), section line width=0.08mm)
  layer_1_datatype_0_plane.subtract(readout_wire_sub_Q1_shortline, prime_cpw_sub_Tee_shortline, second_cpw_sub_Tee_shortline, cut_FeedLeft_shortline, cut_FeedRight_shortline, cut_Readout_shortline, rect_pk_Q1, pocket_P1, pocket_P2, port_endcap_P1_in_1, port_endcap_P2_in_1)
boundaries and excitations:
  rlc_JJ_rect_Lj_1_rect_jj: Lumped RLC Objects=JJ_rect_Lj_1_rect_jj CurrentLine{(-0.785, -0.8, 0.0001) -> (-0.815, -0.8, 0.0001)} RLC_Type=Parallel Inductance=Lj
  Port_P1_in: Lumped Port Objects=Port_P1_in LumpedPortType=Default Modes{Mode1{IntLine{(-2.26, 1, 0.0001) -> (-2.202, 1, 0.0001)} CharImp=Zpi RenormImp=50ohm}} Impedance=50ohm
  Port_P2_in: Lumped Port Objects=Port_P2_in LumpedPortType=Default Modes{Mode1{IntLine{(2.26, 1, 0.0001) -> (2.202, 1, 0.0001)} CharImp=Zpi RenormImp=50ohm}} Impedance=50ohm
mesh:
  JunctionMesh: LengthBased Objects=JJ_rect_Lj_1_rect_jj MaxLength=5um
  ReadoutMesh: LengthBased Objects=[trace_Readout_shortline, second_cpw_Tee_shortline] MaxLength=20um
setups:
  ReadoutSetup: HfssDriven Frequency=6.429254GHz MaxDeltaS=0.01 MaximumPasses=16 MinimumPasses=3 MinimumConvergedPasses=2 PercentRefinement=25 BasisOrder=1 PortAccuracy=2 DrivenSolverType="Direct Solver"
    sweep Locate: 6.129254GHz to 6.729254GHz, 1201 points; Type=Fast
    sweep Fine: 6.401254GHz to 6.421254GHz, 401 points; Type=Fast
source amplitudes:
  Port_P1_in:1: 1W 0deg
  Port_P2_in:1: 0W 0deg

design W160_Eigen (HFSS, Eigenmode, model units mm)
variables:
  Lj = 16nH
geometry:
  layer_1_datatype_0_plane [pec] = polyline(z=0.0001mm, xy in mm: (-2.5, -2) (2.5, -2) (2.5, 2) (-2.5, 2) (-2.5, -2), closed, covered)
  layer_1_datatype_0_plane.thicken(0.0002mm, both sides)
  layer_3_datatype_0_plane [silicon] = polyline(z=-0.25mm, xy in mm: (-2.5, -2) (2.5, -2) (2.5, 2) (-2.5, 2) (-2.5, -2), closed, covered)
  layer_3_datatype_0_plane.thicken(-0.5mm, both sides)
  vacuum_box [vacuum] = polyline(z=0mm, xy in mm: (-2.5, -2) (2.5, -2) (2.5, 2) (-2.5, 2) (-2.5, -2), closed, covered)
  vacuum_box.thicken(3mm, both sides)
  readout_wire_Q1 = polyline(z=0.0001mm, xy in mm: (-0.93, -0.5875) (-0.93, -0.5625) (-0.995, -0.48) (-0.995, -0.375))
  readout_wire_Q1_shortline [pec] = polyline((-0.935mm, -0.5875mm, 0.0001mm) (-0.925mm, -0.5875mm, 0.0001mm))
  readout_wire_Q1_shortline.sweep_along_path(readout_wire_Q1)
  readout_wire_Q1_shortline.thicken(0.0002mm, both sides)
  readout_wire_sub_Q1 = polyline(z=0.0001mm, xy in mm: (-0.93, -0.5875) (-0.93, -0.5625) (-0.995, -0.48) (-0.995, -0.375))
  readout_wire_sub_Q1_shortline = polyline((-0.941mm, -0.5875mm, 0.0001mm) (-0.919mm, -0.5875mm, 0.0001mm))
  readout_wire_sub_Q1_shortline.sweep_along_path(readout_wire_sub_Q1)
  readout_wire_sub_Q1_shortline.thicken(0.0002mm, both sides)
  prime_cpw_Tee = polyline((-0.25mm, 1mm, 0.0001mm) (0.25mm, 1mm, 0.0001mm))
  prime_cpw_Tee_shortline [pec] = polyline((-0.25mm, 1.005mm, 0.0001mm) (-0.25mm, 0.995mm, 0.0001mm))
  prime_cpw_Tee_shortline.sweep_along_path(prime_cpw_Tee)
  prime_cpw_Tee_shortline.thicken(0.0002mm, both sides)
  prime_cpw_sub_Tee = polyline((-0.25mm, 1mm, 0.0001mm) (0.25mm, 1mm, 0.0001mm))
  prime_cpw_sub_Tee_shortline = polyline((-0.25mm, 1.011mm, 0.0001mm) (-0.25mm, 0.989mm, 0.0001mm))
  prime_cpw_sub_Tee_shortline.sweep_along_path(prime_cpw_sub_Tee)
  prime_cpw_sub_Tee_shortline.thicken(0.0002mm, both sides)
  second_cpw_Tee = polyline(z=0.0001mm, xy in mm: (-0.125, 0.973) (0.125, 0.973) (0.125, 0.873))
  second_cpw_Tee.fillet(Vertices=second_cpw_Tee.vertex(at (0.125, 0.973, 0.0001)) Radius=0.025mm Setback=0mm)
  second_cpw_Tee_shortline [pec] = polyline((-0.125mm, 0.978mm, 0.0001mm) (-0.125mm, 0.968mm, 0.0001mm))
  second_cpw_Tee_shortline.sweep_along_path(second_cpw_Tee)
  second_cpw_Tee_shortline.thicken(0.0002mm, both sides)
  second_cpw_sub_Tee = polyline(z=0.0001mm, xy in mm: (-0.125, 0.973) (0.125, 0.973) (0.125, 0.873))
  second_cpw_sub_Tee.fillet(Vertices=second_cpw_sub_Tee.vertex(at (0.125, 0.973, 0.0001)) Radius=0.025mm Setback=0mm)
  second_cpw_sub_Tee_shortline = polyline((-0.125mm, 0.984mm, 0.0001mm) (-0.125mm, 0.962mm, 0.0001mm))
  second_cpw_sub_Tee_shortline.sweep_along_path(second_cpw_sub_Tee)
  second_cpw_sub_Tee_shortline.thicken(0.0002mm, both sides)
  trace_FeedLeft = polyline((-1.975mm, 1mm, 0.0001mm) (-0.25mm, 1mm, 0.0001mm))
  trace_FeedLeft_shortline [pec] = polyline((-1.975mm, 1.005mm, 0.0001mm) (-1.975mm, 0.995mm, 0.0001mm))
  trace_FeedLeft_shortline.sweep_along_path(trace_FeedLeft)
  trace_FeedLeft_shortline.thicken(0.0002mm, both sides)
  cut_FeedLeft = polyline((-1.975mm, 1mm, 0.0001mm) (-0.25mm, 1mm, 0.0001mm))
  cut_FeedLeft_shortline = polyline((-1.975mm, 1.011mm, 0.0001mm) (-1.975mm, 0.989mm, 0.0001mm))
  cut_FeedLeft_shortline.sweep_along_path(cut_FeedLeft)
  cut_FeedLeft_shortline.thicken(0.0002mm, both sides)
  trace_FeedRight = polyline((0.25mm, 1mm, 0.0001mm) (1.975mm, 1mm, 0.0001mm))
  trace_FeedRight_shortline [pec] = polyline((0.25mm, 1.005mm, 0.0001mm) (0.25mm, 0.995mm, 0.0001mm))
  trace_FeedRight_shortline.sweep_along_path(trace_FeedRight)
  trace_FeedRight_shortline.thicken(0.0002mm, both sides)
  cut_FeedRight = polyline((0.25mm, 1mm, 0.0001mm) (1.975mm, 1mm, 0.0001mm))
  cut_FeedRight_shortline = polyline((0.25mm, 1.011mm, 0.0001mm) (0.25mm, 0.989mm, 0.0001mm))
  cut_FeedRight_shortline.sweep_along_path(cut_FeedRight)
  cut_FeedRight_shortline.thicken(0.0002mm, both sides)
  trace_Readout = polyline(z=0.0001mm, xy in mm: (-0.995, -0.375) (-0.995, -0.06324778) (-0.845, -0.06324778) (-0.845, -0.38675222) (-0.695, -0.38675222) (-0.695, -0.06324778) (-0.545, -0.06324778) (-0.545, -0.38675222) (-0.395, -0.38675222) (-0.395, -0.06324778) (-0.245, -0.06324778) (-0.245, -0.38675222) (0.125, -0.38675222) (0.125, 0.873))
  trace_Readout.fillet(Vertices=trace_Readout.vertex(at (-0.995, -0.0632478, 0.0001)) Radius=0.06mm Setback=0mm)
  trace_Readout.fillet(Vertices=trace_Readout.vertex(at (-0.845, -0.0632478, 0.0001)) Radius=0.06mm Setback=0mm)
  trace_Readout.fillet(Vertices=trace_Readout.vertex(at (-0.845, -0.386752, 0.0001)) Radius=0.06mm Setback=0mm)
  trace_Readout.fillet(Vertices=trace_Readout.vertex(at (-0.695, -0.386752, 0.0001)) Radius=0.06mm Setback=0mm)
  trace_Readout.fillet(Vertices=trace_Readout.vertex(at (-0.695, -0.0632478, 0.0001)) Radius=0.06mm Setback=0mm)
  trace_Readout.fillet(Vertices=trace_Readout.vertex(at (-0.545, -0.0632478, 0.0001)) Radius=0.06mm Setback=0mm)
  trace_Readout.fillet(Vertices=trace_Readout.vertex(at (-0.545, -0.386752, 0.0001)) Radius=0.06mm Setback=0mm)
  trace_Readout.fillet(Vertices=trace_Readout.vertex(at (-0.395, -0.386752, 0.0001)) Radius=0.06mm Setback=0mm)
  trace_Readout.fillet(Vertices=trace_Readout.vertex(at (-0.395, -0.0632478, 0.0001)) Radius=0.06mm Setback=0mm)
  trace_Readout.fillet(Vertices=trace_Readout.vertex(at (-0.245, -0.0632478, 0.0001)) Radius=0.06mm Setback=0mm)
  trace_Readout.fillet(Vertices=trace_Readout.vertex(at (-0.245, -0.386752, 0.0001)) Radius=0.06mm Setback=0mm)
  trace_Readout.fillet(Vertices=trace_Readout.vertex(at (0.125, -0.386752, 0.0001)) Radius=0.06mm Setback=0mm)
  trace_Readout_shortline [pec] = polyline((-1mm, -0.375mm, 0.0001mm) (-0.99mm, -0.375mm, 0.0001mm))
  trace_Readout_shortline.sweep_along_path(trace_Readout)
  trace_Readout_shortline.thicken(0.0002mm, both sides)
  cut_Readout = polyline(z=0.0001mm, xy in mm: (-0.995, -0.375) (-0.995, -0.06324778) (-0.845, -0.06324778) (-0.845, -0.38675222) (-0.695, -0.38675222) (-0.695, -0.06324778) (-0.545, -0.06324778) (-0.545, -0.38675222) (-0.395, -0.38675222) (-0.395, -0.06324778) (-0.245, -0.06324778) (-0.245, -0.38675222) (0.125, -0.38675222) (0.125, 0.873))
  cut_Readout.fillet(Vertices=cut_Readout.vertex(at (-0.995, -0.0632478, 0.0001)) Radius=0.06mm Setback=0mm)
  cut_Readout.fillet(Vertices=cut_Readout.vertex(at (-0.845, -0.0632478, 0.0001)) Radius=0.06mm Setback=0mm)
  cut_Readout.fillet(Vertices=cut_Readout.vertex(at (-0.845, -0.386752, 0.0001)) Radius=0.06mm Setback=0mm)
  cut_Readout.fillet(Vertices=cut_Readout.vertex(at (-0.695, -0.386752, 0.0001)) Radius=0.06mm Setback=0mm)
  cut_Readout.fillet(Vertices=cut_Readout.vertex(at (-0.695, -0.0632478, 0.0001)) Radius=0.06mm Setback=0mm)
  cut_Readout.fillet(Vertices=cut_Readout.vertex(at (-0.545, -0.0632478, 0.0001)) Radius=0.06mm Setback=0mm)
  cut_Readout.fillet(Vertices=cut_Readout.vertex(at (-0.545, -0.386752, 0.0001)) Radius=0.06mm Setback=0mm)
  cut_Readout.fillet(Vertices=cut_Readout.vertex(at (-0.395, -0.386752, 0.0001)) Radius=0.06mm Setback=0mm)
  cut_Readout.fillet(Vertices=cut_Readout.vertex(at (-0.395, -0.0632478, 0.0001)) Radius=0.06mm Setback=0mm)
  cut_Readout.fillet(Vertices=cut_Readout.vertex(at (-0.245, -0.0632478, 0.0001)) Radius=0.06mm Setback=0mm)
  cut_Readout.fillet(Vertices=cut_Readout.vertex(at (-0.245, -0.386752, 0.0001)) Radius=0.06mm Setback=0mm)
  cut_Readout.fillet(Vertices=cut_Readout.vertex(at (0.125, -0.386752, 0.0001)) Radius=0.06mm Setback=0mm)
  cut_Readout_shortline = polyline((-1.006mm, -0.375mm, 0.0001mm) (-0.984mm, -0.375mm, 0.0001mm))
  cut_Readout_shortline.sweep_along_path(cut_Readout)
  cut_Readout_shortline.thicken(0.0002mm, both sides)
  pad_top_Q1 [pec] = polyline(z=0.0001mm, xy in mm: (-0.815, -1.0125) (-0.815, -0.5875) (-0.905, -0.5875) (-0.905, -1.0125) (-0.815, -1.0125), closed, covered)
  pad_top_Q1.thicken(0.0002mm, both sides)
  pad_bot_Q1 [pec] = polyline(z=0.0001mm, xy in mm: (-0.695, -1.0125) (-0.695, -0.5875) (-0.785, -0.5875) (-0.785, -1.0125) (-0.695, -1.0125), closed, covered)
  pad_bot_Q1.thicken(0.0002mm, both sides)
  rect_pk_Q1 = polyline(z=0.0001mm, xy in mm: (-0.475, -1.125) (-0.475, -0.475) (-1.125, -0.475) (-1.125, -1.125) (-0.475, -1.125), closed, covered)
  rect_pk_Q1.thicken(0.0002mm, both sides)
  readout_connector_pad_Q1 [pec] = polyline(z=0.0001mm, xy in mm: (-0.92, -0.7475) (-0.92, -0.5875) (-0.95, -0.5875) (-0.95, -0.7475) (-0.92, -0.7475), closed, covered)
  readout_connector_pad_Q1.thicken(0.0002mm, both sides)
  launch_pad_P1 [pec] = polyline(z=0.0001mm, xy in mm: (-2, 1.005) (-2.122, 1.04) (-2.202, 1.04) (-2.202, 0.96) (-2.122, 0.96) (-2, 0.995) (-1.975, 0.995) (-1.975, 1.005) (-2, 1.005), closed, covered)
  launch_pad_P1.thicken(0.0002mm, both sides)
  pocket_P1 = polyline(z=0.0001mm, xy in mm: (-2, 1.011) (-2.122, 1.098) (-2.26, 1.098) (-2.26, 0.902) (-2.122, 0.902) (-2, 0.989) (-1.975, 0.989) (-1.975, 1.011) (-2, 1.011), closed, covered)
  pocket_P1.thicken(0.0002mm, both sides)
  launch_pad_P2 [pec] = polyline(z=0.0001mm, xy in mm: (2, 0.995) (2.122, 0.96) (2.202, 0.96) (2.202, 1.04) (2.122, 1.04) (2, 1.005) (1.975, 1.005) (1.975, 0.995) (2, 0.995), closed, covered)
  launch_pad_P2.thicken(0.0002mm, both sides)
  pocket_P2 = polyline(z=0.0001mm, xy in mm: (2, 0.989) (2.122, 0.902) (2.26, 0.902) (2.26, 1.098) (2.122, 1.098) (2, 1.011) (1.975, 1.011) (1.975, 0.989) (2, 0.989), closed, covered)
  pocket_P2.thicken(0.0002mm, both sides)
  JJ_Lj_1_rect_jj_ = polyline((-0.785mm, -0.8mm, 0.0001mm) (-0.815mm, -0.8mm, 0.0001mm))
  JJ_rect_Lj_1_rect_jj = polyline((-0.785mm, -0.8mm, 0.0001mm) (-0.815mm, -0.8mm, 0.0001mm), section line width=0.02mm)
  endcap_P1_in_1 = polyline((-2.26mm, 1mm, 0.0001mm) (-2.202mm, 1mm, 0.0001mm), section line width=0.196mm)
  endcap_P1_in_1.thicken(0.0002mm, both sides)
  endcap_P2_in_1 = polyline((2.26mm, 1mm, 0.0001mm) (2.202mm, 1mm, 0.0001mm), section line width=0.196mm)
  endcap_P2_in_1.thicken(0.0002mm, both sides)
  layer_1_datatype_0_plane.subtract(readout_wire_sub_Q1_shortline, prime_cpw_sub_Tee_shortline, second_cpw_sub_Tee_shortline, cut_FeedLeft_shortline, cut_FeedRight_shortline, cut_Readout_shortline, rect_pk_Q1, pocket_P1, pocket_P2, endcap_P1_in_1, endcap_P2_in_1)
boundaries and excitations:
  rlc_JJ_rect_Lj_1_rect_jj: Lumped RLC Objects=JJ_rect_Lj_1_rect_jj CurrentLine{(-0.785, -0.8, 0.0001) -> (-0.815, -0.8, 0.0001)} RLC_Type=Parallel Inductance=Lj
mesh:
  JunctionMesh: LengthBased Objects=JJ_rect_Lj_1_rect_jj MaxLength=5um
setups:
  EigenSetup: HfssEigen MinimumFrequency=2GHz NumModes=2 MaxDeltaFreq=0.3 ConvergeOnRealFreq=false MaximumPasses=16 MinimumPasses=3 MinimumConvergedPasses=2 PercentRefinement=25 BasisOrder=1
source amplitudes:
  #-10:1: 0 0
  #-10:2: 1 0
reports:
  Freq. vs. pass: re(Mode(1)), re(Mode(2)) vs Pass on EigenSetup : AdaptivePass [Lj=16nH]

design W160_Driven (HFSS, HFSS Modal Network, model units mm)
variables:
  Lj = 16nH
geometry:
  layer_1_datatype_0_plane [pec] = polyline(z=0.0001mm, xy in mm: (-2.5, -2) (2.5, -2) (2.5, 2) (-2.5, 2) (-2.5, -2), closed, covered)
  layer_1_datatype_0_plane.thicken(0.0002mm, both sides)
  layer_3_datatype_0_plane [silicon] = polyline(z=-0.25mm, xy in mm: (-2.5, -2) (2.5, -2) (2.5, 2) (-2.5, 2) (-2.5, -2), closed, covered)
  layer_3_datatype_0_plane.thicken(-0.5mm, both sides)
  vacuum_box [vacuum] = polyline(z=0mm, xy in mm: (-2.5, -2) (2.5, -2) (2.5, 2) (-2.5, 2) (-2.5, -2), closed, covered)
  vacuum_box.thicken(3mm, both sides)
  readout_wire_Q1 = polyline(z=0.0001mm, xy in mm: (-0.93, -0.5875) (-0.93, -0.5625) (-0.995, -0.48) (-0.995, -0.375))
  readout_wire_Q1_shortline [pec] = polyline((-0.935mm, -0.5875mm, 0.0001mm) (-0.925mm, -0.5875mm, 0.0001mm))
  readout_wire_Q1_shortline.sweep_along_path(readout_wire_Q1)
  readout_wire_Q1_shortline.thicken(0.0002mm, both sides)
  readout_wire_sub_Q1 = polyline(z=0.0001mm, xy in mm: (-0.93, -0.5875) (-0.93, -0.5625) (-0.995, -0.48) (-0.995, -0.375))
  readout_wire_sub_Q1_shortline = polyline((-0.941mm, -0.5875mm, 0.0001mm) (-0.919mm, -0.5875mm, 0.0001mm))
  readout_wire_sub_Q1_shortline.sweep_along_path(readout_wire_sub_Q1)
  readout_wire_sub_Q1_shortline.thicken(0.0002mm, both sides)
  prime_cpw_Tee = polyline((-0.25mm, 1mm, 0.0001mm) (0.25mm, 1mm, 0.0001mm))
  prime_cpw_Tee_shortline [pec] = polyline((-0.25mm, 1.005mm, 0.0001mm) (-0.25mm, 0.995mm, 0.0001mm))
  prime_cpw_Tee_shortline.sweep_along_path(prime_cpw_Tee)
  prime_cpw_Tee_shortline.thicken(0.0002mm, both sides)
  prime_cpw_sub_Tee = polyline((-0.25mm, 1mm, 0.0001mm) (0.25mm, 1mm, 0.0001mm))
  prime_cpw_sub_Tee_shortline = polyline((-0.25mm, 1.011mm, 0.0001mm) (-0.25mm, 0.989mm, 0.0001mm))
  prime_cpw_sub_Tee_shortline.sweep_along_path(prime_cpw_sub_Tee)
  prime_cpw_sub_Tee_shortline.thicken(0.0002mm, both sides)
  second_cpw_Tee = polyline(z=0.0001mm, xy in mm: (-0.125, 0.973) (0.125, 0.973) (0.125, 0.873))
  second_cpw_Tee.fillet(Vertices=second_cpw_Tee.vertex(at (0.125, 0.973, 0.0001)) Radius=0.025mm Setback=0mm)
  second_cpw_Tee_shortline [pec] = polyline((-0.125mm, 0.978mm, 0.0001mm) (-0.125mm, 0.968mm, 0.0001mm))
  second_cpw_Tee_shortline.sweep_along_path(second_cpw_Tee)
  second_cpw_Tee_shortline.thicken(0.0002mm, both sides)
  second_cpw_sub_Tee = polyline(z=0.0001mm, xy in mm: (-0.125, 0.973) (0.125, 0.973) (0.125, 0.873))
  second_cpw_sub_Tee.fillet(Vertices=second_cpw_sub_Tee.vertex(at (0.125, 0.973, 0.0001)) Radius=0.025mm Setback=0mm)
  second_cpw_sub_Tee_shortline = polyline((-0.125mm, 0.984mm, 0.0001mm) (-0.125mm, 0.962mm, 0.0001mm))
  second_cpw_sub_Tee_shortline.sweep_along_path(second_cpw_sub_Tee)
  second_cpw_sub_Tee_shortline.thicken(0.0002mm, both sides)
  trace_FeedLeft = polyline((-1.975mm, 1mm, 0.0001mm) (-0.25mm, 1mm, 0.0001mm))
  trace_FeedLeft_shortline [pec] = polyline((-1.975mm, 1.005mm, 0.0001mm) (-1.975mm, 0.995mm, 0.0001mm))
  trace_FeedLeft_shortline.sweep_along_path(trace_FeedLeft)
  trace_FeedLeft_shortline.thicken(0.0002mm, both sides)
  cut_FeedLeft = polyline((-1.975mm, 1mm, 0.0001mm) (-0.25mm, 1mm, 0.0001mm))
  cut_FeedLeft_shortline = polyline((-1.975mm, 1.011mm, 0.0001mm) (-1.975mm, 0.989mm, 0.0001mm))
  cut_FeedLeft_shortline.sweep_along_path(cut_FeedLeft)
  cut_FeedLeft_shortline.thicken(0.0002mm, both sides)
  trace_FeedRight = polyline((0.25mm, 1mm, 0.0001mm) (1.975mm, 1mm, 0.0001mm))
  trace_FeedRight_shortline [pec] = polyline((0.25mm, 1.005mm, 0.0001mm) (0.25mm, 0.995mm, 0.0001mm))
  trace_FeedRight_shortline.sweep_along_path(trace_FeedRight)
  trace_FeedRight_shortline.thicken(0.0002mm, both sides)
  cut_FeedRight = polyline((0.25mm, 1mm, 0.0001mm) (1.975mm, 1mm, 0.0001mm))
  cut_FeedRight_shortline = polyline((0.25mm, 1.011mm, 0.0001mm) (0.25mm, 0.989mm, 0.0001mm))
  cut_FeedRight_shortline.sweep_along_path(cut_FeedRight)
  cut_FeedRight_shortline.thicken(0.0002mm, both sides)
  trace_Readout = polyline(z=0.0001mm, xy in mm: (-0.995, -0.375) (-0.995, -0.06324778) (-0.845, -0.06324778) (-0.845, -0.38675222) (-0.695, -0.38675222) (-0.695, -0.06324778) (-0.545, -0.06324778) (-0.545, -0.38675222) (-0.395, -0.38675222) (-0.395, -0.06324778) (-0.245, -0.06324778) (-0.245, -0.38675222) (0.125, -0.38675222) (0.125, 0.873))
  trace_Readout.fillet(Vertices=trace_Readout.vertex(at (-0.995, -0.0632478, 0.0001)) Radius=0.06mm Setback=0mm)
  trace_Readout.fillet(Vertices=trace_Readout.vertex(at (-0.845, -0.0632478, 0.0001)) Radius=0.06mm Setback=0mm)
  trace_Readout.fillet(Vertices=trace_Readout.vertex(at (-0.845, -0.386752, 0.0001)) Radius=0.06mm Setback=0mm)
  trace_Readout.fillet(Vertices=trace_Readout.vertex(at (-0.695, -0.386752, 0.0001)) Radius=0.06mm Setback=0mm)
  trace_Readout.fillet(Vertices=trace_Readout.vertex(at (-0.695, -0.0632478, 0.0001)) Radius=0.06mm Setback=0mm)
  trace_Readout.fillet(Vertices=trace_Readout.vertex(at (-0.545, -0.0632478, 0.0001)) Radius=0.06mm Setback=0mm)
  trace_Readout.fillet(Vertices=trace_Readout.vertex(at (-0.545, -0.386752, 0.0001)) Radius=0.06mm Setback=0mm)
  trace_Readout.fillet(Vertices=trace_Readout.vertex(at (-0.395, -0.386752, 0.0001)) Radius=0.06mm Setback=0mm)
  trace_Readout.fillet(Vertices=trace_Readout.vertex(at (-0.395, -0.0632478, 0.0001)) Radius=0.06mm Setback=0mm)
  trace_Readout.fillet(Vertices=trace_Readout.vertex(at (-0.245, -0.0632478, 0.0001)) Radius=0.06mm Setback=0mm)
  trace_Readout.fillet(Vertices=trace_Readout.vertex(at (-0.245, -0.386752, 0.0001)) Radius=0.06mm Setback=0mm)
  trace_Readout.fillet(Vertices=trace_Readout.vertex(at (0.125, -0.386752, 0.0001)) Radius=0.06mm Setback=0mm)
  trace_Readout_shortline [pec] = polyline((-1mm, -0.375mm, 0.0001mm) (-0.99mm, -0.375mm, 0.0001mm))
  trace_Readout_shortline.sweep_along_path(trace_Readout)
  trace_Readout_shortline.thicken(0.0002mm, both sides)
  cut_Readout = polyline(z=0.0001mm, xy in mm: (-0.995, -0.375) (-0.995, -0.06324778) (-0.845, -0.06324778) (-0.845, -0.38675222) (-0.695, -0.38675222) (-0.695, -0.06324778) (-0.545, -0.06324778) (-0.545, -0.38675222) (-0.395, -0.38675222) (-0.395, -0.06324778) (-0.245, -0.06324778) (-0.245, -0.38675222) (0.125, -0.38675222) (0.125, 0.873))
  cut_Readout.fillet(Vertices=cut_Readout.vertex(at (-0.995, -0.0632478, 0.0001)) Radius=0.06mm Setback=0mm)
  cut_Readout.fillet(Vertices=cut_Readout.vertex(at (-0.845, -0.0632478, 0.0001)) Radius=0.06mm Setback=0mm)
  cut_Readout.fillet(Vertices=cut_Readout.vertex(at (-0.845, -0.386752, 0.0001)) Radius=0.06mm Setback=0mm)
  cut_Readout.fillet(Vertices=cut_Readout.vertex(at (-0.695, -0.386752, 0.0001)) Radius=0.06mm Setback=0mm)
  cut_Readout.fillet(Vertices=cut_Readout.vertex(at (-0.695, -0.0632478, 0.0001)) Radius=0.06mm Setback=0mm)
  cut_Readout.fillet(Vertices=cut_Readout.vertex(at (-0.545, -0.0632478, 0.0001)) Radius=0.06mm Setback=0mm)
  cut_Readout.fillet(Vertices=cut_Readout.vertex(at (-0.545, -0.386752, 0.0001)) Radius=0.06mm Setback=0mm)
  cut_Readout.fillet(Vertices=cut_Readout.vertex(at (-0.395, -0.386752, 0.0001)) Radius=0.06mm Setback=0mm)
  cut_Readout.fillet(Vertices=cut_Readout.vertex(at (-0.395, -0.0632478, 0.0001)) Radius=0.06mm Setback=0mm)
  cut_Readout.fillet(Vertices=cut_Readout.vertex(at (-0.245, -0.0632478, 0.0001)) Radius=0.06mm Setback=0mm)
  cut_Readout.fillet(Vertices=cut_Readout.vertex(at (-0.245, -0.386752, 0.0001)) Radius=0.06mm Setback=0mm)
  cut_Readout.fillet(Vertices=cut_Readout.vertex(at (0.125, -0.386752, 0.0001)) Radius=0.06mm Setback=0mm)
  cut_Readout_shortline = polyline((-1.006mm, -0.375mm, 0.0001mm) (-0.984mm, -0.375mm, 0.0001mm))
  cut_Readout_shortline.sweep_along_path(cut_Readout)
  cut_Readout_shortline.thicken(0.0002mm, both sides)
  pad_top_Q1 [pec] = polyline(z=0.0001mm, xy in mm: (-0.815, -1.0125) (-0.815, -0.5875) (-0.905, -0.5875) (-0.905, -1.0125) (-0.815, -1.0125), closed, covered)
  pad_top_Q1.thicken(0.0002mm, both sides)
  pad_bot_Q1 [pec] = polyline(z=0.0001mm, xy in mm: (-0.695, -1.0125) (-0.695, -0.5875) (-0.785, -0.5875) (-0.785, -1.0125) (-0.695, -1.0125), closed, covered)
  pad_bot_Q1.thicken(0.0002mm, both sides)
  rect_pk_Q1 = polyline(z=0.0001mm, xy in mm: (-0.475, -1.125) (-0.475, -0.475) (-1.125, -0.475) (-1.125, -1.125) (-0.475, -1.125), closed, covered)
  rect_pk_Q1.thicken(0.0002mm, both sides)
  readout_connector_pad_Q1 [pec] = polyline(z=0.0001mm, xy in mm: (-0.92, -0.7475) (-0.92, -0.5875) (-0.95, -0.5875) (-0.95, -0.7475) (-0.92, -0.7475), closed, covered)
  readout_connector_pad_Q1.thicken(0.0002mm, both sides)
  launch_pad_P1 [pec] = polyline(z=0.0001mm, xy in mm: (-2, 1.005) (-2.122, 1.04) (-2.202, 1.04) (-2.202, 0.96) (-2.122, 0.96) (-2, 0.995) (-1.975, 0.995) (-1.975, 1.005) (-2, 1.005), closed, covered)
  launch_pad_P1.thicken(0.0002mm, both sides)
  pocket_P1 = polyline(z=0.0001mm, xy in mm: (-2, 1.011) (-2.122, 1.098) (-2.26, 1.098) (-2.26, 0.902) (-2.122, 0.902) (-2, 0.989) (-1.975, 0.989) (-1.975, 1.011) (-2, 1.011), closed, covered)
  pocket_P1.thicken(0.0002mm, both sides)
  launch_pad_P2 [pec] = polyline(z=0.0001mm, xy in mm: (2, 0.995) (2.122, 0.96) (2.202, 0.96) (2.202, 1.04) (2.122, 1.04) (2, 1.005) (1.975, 1.005) (1.975, 0.995) (2, 0.995), closed, covered)
  launch_pad_P2.thicken(0.0002mm, both sides)
  pocket_P2 = polyline(z=0.0001mm, xy in mm: (2, 0.989) (2.122, 0.902) (2.26, 0.902) (2.26, 1.098) (2.122, 1.098) (2, 1.011) (1.975, 1.011) (1.975, 0.989) (2, 0.989), closed, covered)
  pocket_P2.thicken(0.0002mm, both sides)
  JJ_Lj_1_rect_jj_ = polyline((-0.785mm, -0.8mm, 0.0001mm) (-0.815mm, -0.8mm, 0.0001mm))
  JJ_rect_Lj_1_rect_jj = polyline((-0.785mm, -0.8mm, 0.0001mm) (-0.815mm, -0.8mm, 0.0001mm), section line width=0.02mm)
  port_endcap_P1_in_1 = polyline((-2.26mm, 1mm, 0.0001mm) (-2.202mm, 1mm, 0.0001mm), section line width=0.196mm)
  port_endcap_P1_in_1.thicken(0.0002mm, both sides)
  port_endcap_P2_in_1 = polyline((2.26mm, 1mm, 0.0001mm) (2.202mm, 1mm, 0.0001mm), section line width=0.196mm)
  port_endcap_P2_in_1.thicken(0.0002mm, both sides)
  Port_P1_in = polyline((-2.26mm, 1mm, 0.0001mm) (-2.202mm, 1mm, 0.0001mm), section line width=0.08mm)
  Port_P2_in = polyline((2.26mm, 1mm, 0.0001mm) (2.202mm, 1mm, 0.0001mm), section line width=0.08mm)
  layer_1_datatype_0_plane.subtract(readout_wire_sub_Q1_shortline, prime_cpw_sub_Tee_shortline, second_cpw_sub_Tee_shortline, cut_FeedLeft_shortline, cut_FeedRight_shortline, cut_Readout_shortline, rect_pk_Q1, pocket_P1, pocket_P2, port_endcap_P1_in_1, port_endcap_P2_in_1)
boundaries and excitations:
  rlc_JJ_rect_Lj_1_rect_jj: Lumped RLC Objects=JJ_rect_Lj_1_rect_jj CurrentLine{(-0.785, -0.8, 0.0001) -> (-0.815, -0.8, 0.0001)} RLC_Type=Parallel Inductance=Lj
  Port_P1_in: Lumped Port Objects=Port_P1_in LumpedPortType=Default Modes{Mode1{IntLine{(-2.26, 1, 0.0001) -> (-2.202, 1, 0.0001)} CharImp=Zpi RenormImp=50ohm}} Impedance=50ohm
  Port_P2_in: Lumped Port Objects=Port_P2_in LumpedPortType=Default Modes{Mode1{IntLine{(2.26, 1, 0.0001) -> (2.202, 1, 0.0001)} CharImp=Zpi RenormImp=50ohm}} Impedance=50ohm
mesh:
  JunctionMesh: LengthBased Objects=JJ_rect_Lj_1_rect_jj MaxLength=5um
  ReadoutMesh: LengthBased Objects=[trace_Readout_shortline, second_cpw_Tee_shortline] MaxLength=20um
setups:
  ReadoutSetup: HfssDriven Frequency=6.4549317GHz MaxDeltaS=0.01 MaximumPasses=16 MinimumPasses=3 MinimumConvergedPasses=2 PercentRefinement=25 BasisOrder=1 PortAccuracy=2 DrivenSolverType="Direct Solver"
    sweep Locate: 6.3949317GHz to 6.5149317GHz, 241 points; Type=Fast
    sweep Fine: 6.4324317GHz to 6.4524317GHz, 401 points; Type=Fast
source amplitudes:
  Port_P1_in:1: 1W 0deg
  Port_P2_in:1: 0W 0deg

design W240_Eigen (HFSS, Eigenmode, model units mm)
variables:
  Lj = 16nH
geometry:
  layer_1_datatype_0_plane [pec] = polyline(z=0.0001mm, xy in mm: (-2.5, -2) (2.5, -2) (2.5, 2) (-2.5, 2) (-2.5, -2), closed, covered)
  layer_1_datatype_0_plane.thicken(0.0002mm, both sides)
  layer_3_datatype_0_plane [silicon] = polyline(z=-0.25mm, xy in mm: (-2.5, -2) (2.5, -2) (2.5, 2) (-2.5, 2) (-2.5, -2), closed, covered)
  layer_3_datatype_0_plane.thicken(-0.5mm, both sides)
  vacuum_box [vacuum] = polyline(z=0mm, xy in mm: (-2.5, -2) (2.5, -2) (2.5, 2) (-2.5, 2) (-2.5, -2), closed, covered)
  vacuum_box.thicken(3mm, both sides)
  readout_wire_Q1 = polyline(z=0.0001mm, xy in mm: (-0.93, -0.5875) (-0.93, -0.5625) (-0.995, -0.48) (-0.995, -0.375))
  readout_wire_Q1_shortline [pec] = polyline((-0.935mm, -0.5875mm, 0.0001mm) (-0.925mm, -0.5875mm, 0.0001mm))
  readout_wire_Q1_shortline.sweep_along_path(readout_wire_Q1)
  readout_wire_Q1_shortline.thicken(0.0002mm, both sides)
  readout_wire_sub_Q1 = polyline(z=0.0001mm, xy in mm: (-0.93, -0.5875) (-0.93, -0.5625) (-0.995, -0.48) (-0.995, -0.375))
  readout_wire_sub_Q1_shortline = polyline((-0.941mm, -0.5875mm, 0.0001mm) (-0.919mm, -0.5875mm, 0.0001mm))
  readout_wire_sub_Q1_shortline.sweep_along_path(readout_wire_sub_Q1)
  readout_wire_sub_Q1_shortline.thicken(0.0002mm, both sides)
  prime_cpw_Tee = polyline((-0.25mm, 1mm, 0.0001mm) (0.25mm, 1mm, 0.0001mm))
  prime_cpw_Tee_shortline [pec] = polyline((-0.25mm, 1.005mm, 0.0001mm) (-0.25mm, 0.995mm, 0.0001mm))
  prime_cpw_Tee_shortline.sweep_along_path(prime_cpw_Tee)
  prime_cpw_Tee_shortline.thicken(0.0002mm, both sides)
  prime_cpw_sub_Tee = polyline((-0.25mm, 1mm, 0.0001mm) (0.25mm, 1mm, 0.0001mm))
  prime_cpw_sub_Tee_shortline = polyline((-0.25mm, 1.011mm, 0.0001mm) (-0.25mm, 0.989mm, 0.0001mm))
  prime_cpw_sub_Tee_shortline.sweep_along_path(prime_cpw_sub_Tee)
  prime_cpw_sub_Tee_shortline.thicken(0.0002mm, both sides)
  second_cpw_Tee = polyline(z=0.0001mm, xy in mm: (-0.125, 0.973) (0.125, 0.973) (0.125, 0.873))
  second_cpw_Tee.fillet(Vertices=second_cpw_Tee.vertex(at (0.125, 0.973, 0.0001)) Radius=0.025mm Setback=0mm)
  second_cpw_Tee_shortline [pec] = polyline((-0.125mm, 0.978mm, 0.0001mm) (-0.125mm, 0.968mm, 0.0001mm))
  second_cpw_Tee_shortline.sweep_along_path(second_cpw_Tee)
  second_cpw_Tee_shortline.thicken(0.0002mm, both sides)
  second_cpw_sub_Tee = polyline(z=0.0001mm, xy in mm: (-0.125, 0.973) (0.125, 0.973) (0.125, 0.873))
  second_cpw_sub_Tee.fillet(Vertices=second_cpw_sub_Tee.vertex(at (0.125, 0.973, 0.0001)) Radius=0.025mm Setback=0mm)
  second_cpw_sub_Tee_shortline = polyline((-0.125mm, 0.984mm, 0.0001mm) (-0.125mm, 0.962mm, 0.0001mm))
  second_cpw_sub_Tee_shortline.sweep_along_path(second_cpw_sub_Tee)
  second_cpw_sub_Tee_shortline.thicken(0.0002mm, both sides)
  trace_FeedLeft = polyline((-1.975mm, 1mm, 0.0001mm) (-0.25mm, 1mm, 0.0001mm))
  trace_FeedLeft_shortline [pec] = polyline((-1.975mm, 1.005mm, 0.0001mm) (-1.975mm, 0.995mm, 0.0001mm))
  trace_FeedLeft_shortline.sweep_along_path(trace_FeedLeft)
  trace_FeedLeft_shortline.thicken(0.0002mm, both sides)
  cut_FeedLeft = polyline((-1.975mm, 1mm, 0.0001mm) (-0.25mm, 1mm, 0.0001mm))
  cut_FeedLeft_shortline = polyline((-1.975mm, 1.011mm, 0.0001mm) (-1.975mm, 0.989mm, 0.0001mm))
  cut_FeedLeft_shortline.sweep_along_path(cut_FeedLeft)
  cut_FeedLeft_shortline.thicken(0.0002mm, both sides)
  trace_FeedRight = polyline((0.25mm, 1mm, 0.0001mm) (1.975mm, 1mm, 0.0001mm))
  trace_FeedRight_shortline [pec] = polyline((0.25mm, 1.005mm, 0.0001mm) (0.25mm, 0.995mm, 0.0001mm))
  trace_FeedRight_shortline.sweep_along_path(trace_FeedRight)
  trace_FeedRight_shortline.thicken(0.0002mm, both sides)
  cut_FeedRight = polyline((0.25mm, 1mm, 0.0001mm) (1.975mm, 1mm, 0.0001mm))
  cut_FeedRight_shortline = polyline((0.25mm, 1.011mm, 0.0001mm) (0.25mm, 0.989mm, 0.0001mm))
  cut_FeedRight_shortline.sweep_along_path(cut_FeedRight)
  cut_FeedRight_shortline.thicken(0.0002mm, both sides)
  trace_Readout = polyline(z=0.0001mm, xy in mm: (-0.995, -0.375) (-0.995, -0.06324778) (-0.845, -0.06324778) (-0.845, -0.38675222) (-0.695, -0.38675222) (-0.695, -0.06324778) (-0.545, -0.06324778) (-0.545, -0.38675222) (-0.395, -0.38675222) (-0.395, -0.06324778) (-0.245, -0.06324778) (-0.245, -0.38675222) (0.125, -0.38675222) (0.125, 0.873))
  trace_Readout.fillet(Vertices=trace_Readout.vertex(at (-0.995, -0.0632478, 0.0001)) Radius=0.06mm Setback=0mm)
  trace_Readout.fillet(Vertices=trace_Readout.vertex(at (-0.845, -0.0632478, 0.0001)) Radius=0.06mm Setback=0mm)
  trace_Readout.fillet(Vertices=trace_Readout.vertex(at (-0.845, -0.386752, 0.0001)) Radius=0.06mm Setback=0mm)
  trace_Readout.fillet(Vertices=trace_Readout.vertex(at (-0.695, -0.386752, 0.0001)) Radius=0.06mm Setback=0mm)
  trace_Readout.fillet(Vertices=trace_Readout.vertex(at (-0.695, -0.0632478, 0.0001)) Radius=0.06mm Setback=0mm)
  trace_Readout.fillet(Vertices=trace_Readout.vertex(at (-0.545, -0.0632478, 0.0001)) Radius=0.06mm Setback=0mm)
  trace_Readout.fillet(Vertices=trace_Readout.vertex(at (-0.545, -0.386752, 0.0001)) Radius=0.06mm Setback=0mm)
  trace_Readout.fillet(Vertices=trace_Readout.vertex(at (-0.395, -0.386752, 0.0001)) Radius=0.06mm Setback=0mm)
  trace_Readout.fillet(Vertices=trace_Readout.vertex(at (-0.395, -0.0632478, 0.0001)) Radius=0.06mm Setback=0mm)
  trace_Readout.fillet(Vertices=trace_Readout.vertex(at (-0.245, -0.0632478, 0.0001)) Radius=0.06mm Setback=0mm)
  trace_Readout.fillet(Vertices=trace_Readout.vertex(at (-0.245, -0.386752, 0.0001)) Radius=0.06mm Setback=0mm)
  trace_Readout.fillet(Vertices=trace_Readout.vertex(at (0.125, -0.386752, 0.0001)) Radius=0.06mm Setback=0mm)
  trace_Readout_shortline [pec] = polyline((-1mm, -0.375mm, 0.0001mm) (-0.99mm, -0.375mm, 0.0001mm))
  trace_Readout_shortline.sweep_along_path(trace_Readout)
  trace_Readout_shortline.thicken(0.0002mm, both sides)
  cut_Readout = polyline(z=0.0001mm, xy in mm: (-0.995, -0.375) (-0.995, -0.06324778) (-0.845, -0.06324778) (-0.845, -0.38675222) (-0.695, -0.38675222) (-0.695, -0.06324778) (-0.545, -0.06324778) (-0.545, -0.38675222) (-0.395, -0.38675222) (-0.395, -0.06324778) (-0.245, -0.06324778) (-0.245, -0.38675222) (0.125, -0.38675222) (0.125, 0.873))
  cut_Readout.fillet(Vertices=cut_Readout.vertex(at (-0.995, -0.0632478, 0.0001)) Radius=0.06mm Setback=0mm)
  cut_Readout.fillet(Vertices=cut_Readout.vertex(at (-0.845, -0.0632478, 0.0001)) Radius=0.06mm Setback=0mm)
  cut_Readout.fillet(Vertices=cut_Readout.vertex(at (-0.845, -0.386752, 0.0001)) Radius=0.06mm Setback=0mm)
  cut_Readout.fillet(Vertices=cut_Readout.vertex(at (-0.695, -0.386752, 0.0001)) Radius=0.06mm Setback=0mm)
  cut_Readout.fillet(Vertices=cut_Readout.vertex(at (-0.695, -0.0632478, 0.0001)) Radius=0.06mm Setback=0mm)
  cut_Readout.fillet(Vertices=cut_Readout.vertex(at (-0.545, -0.0632478, 0.0001)) Radius=0.06mm Setback=0mm)
  cut_Readout.fillet(Vertices=cut_Readout.vertex(at (-0.545, -0.386752, 0.0001)) Radius=0.06mm Setback=0mm)
  cut_Readout.fillet(Vertices=cut_Readout.vertex(at (-0.395, -0.386752, 0.0001)) Radius=0.06mm Setback=0mm)
  cut_Readout.fillet(Vertices=cut_Readout.vertex(at (-0.395, -0.0632478, 0.0001)) Radius=0.06mm Setback=0mm)
  cut_Readout.fillet(Vertices=cut_Readout.vertex(at (-0.245, -0.0632478, 0.0001)) Radius=0.06mm Setback=0mm)
  cut_Readout.fillet(Vertices=cut_Readout.vertex(at (-0.245, -0.386752, 0.0001)) Radius=0.06mm Setback=0mm)
  cut_Readout.fillet(Vertices=cut_Readout.vertex(at (0.125, -0.386752, 0.0001)) Radius=0.06mm Setback=0mm)
  cut_Readout_shortline = polyline((-1.006mm, -0.375mm, 0.0001mm) (-0.984mm, -0.375mm, 0.0001mm))
  cut_Readout_shortline.sweep_along_path(cut_Readout)
  cut_Readout_shortline.thicken(0.0002mm, both sides)
  pad_top_Q1 [pec] = polyline(z=0.0001mm, xy in mm: (-0.815, -1.0125) (-0.815, -0.5875) (-0.905, -0.5875) (-0.905, -1.0125) (-0.815, -1.0125), closed, covered)
  pad_top_Q1.thicken(0.0002mm, both sides)
  pad_bot_Q1 [pec] = polyline(z=0.0001mm, xy in mm: (-0.695, -1.0125) (-0.695, -0.5875) (-0.785, -0.5875) (-0.785, -1.0125) (-0.695, -1.0125), closed, covered)
  pad_bot_Q1.thicken(0.0002mm, both sides)
  rect_pk_Q1 = polyline(z=0.0001mm, xy in mm: (-0.475, -1.125) (-0.475, -0.475) (-1.125, -0.475) (-1.125, -1.125) (-0.475, -1.125), closed, covered)
  rect_pk_Q1.thicken(0.0002mm, both sides)
  readout_connector_pad_Q1 [pec] = polyline(z=0.0001mm, xy in mm: (-0.92, -0.8275) (-0.92, -0.5875) (-0.95, -0.5875) (-0.95, -0.8275) (-0.92, -0.8275), closed, covered)
  readout_connector_pad_Q1.thicken(0.0002mm, both sides)
  launch_pad_P1 [pec] = polyline(z=0.0001mm, xy in mm: (-2, 1.005) (-2.122, 1.04) (-2.202, 1.04) (-2.202, 0.96) (-2.122, 0.96) (-2, 0.995) (-1.975, 0.995) (-1.975, 1.005) (-2, 1.005), closed, covered)
  launch_pad_P1.thicken(0.0002mm, both sides)
  pocket_P1 = polyline(z=0.0001mm, xy in mm: (-2, 1.011) (-2.122, 1.098) (-2.26, 1.098) (-2.26, 0.902) (-2.122, 0.902) (-2, 0.989) (-1.975, 0.989) (-1.975, 1.011) (-2, 1.011), closed, covered)
  pocket_P1.thicken(0.0002mm, both sides)
  launch_pad_P2 [pec] = polyline(z=0.0001mm, xy in mm: (2, 0.995) (2.122, 0.96) (2.202, 0.96) (2.202, 1.04) (2.122, 1.04) (2, 1.005) (1.975, 1.005) (1.975, 0.995) (2, 0.995), closed, covered)
  launch_pad_P2.thicken(0.0002mm, both sides)
  pocket_P2 = polyline(z=0.0001mm, xy in mm: (2, 0.989) (2.122, 0.902) (2.26, 0.902) (2.26, 1.098) (2.122, 1.098) (2, 1.011) (1.975, 1.011) (1.975, 0.989) (2, 0.989), closed, covered)
  pocket_P2.thicken(0.0002mm, both sides)
  JJ_Lj_1_rect_jj_ = polyline((-0.785mm, -0.8mm, 0.0001mm) (-0.815mm, -0.8mm, 0.0001mm))
  JJ_rect_Lj_1_rect_jj = polyline((-0.785mm, -0.8mm, 0.0001mm) (-0.815mm, -0.8mm, 0.0001mm), section line width=0.02mm)
  endcap_P1_in_1 = polyline((-2.26mm, 1mm, 0.0001mm) (-2.202mm, 1mm, 0.0001mm), section line width=0.196mm)
  endcap_P1_in_1.thicken(0.0002mm, both sides)
  endcap_P2_in_1 = polyline((2.26mm, 1mm, 0.0001mm) (2.202mm, 1mm, 0.0001mm), section line width=0.196mm)
  endcap_P2_in_1.thicken(0.0002mm, both sides)
  layer_1_datatype_0_plane.subtract(readout_wire_sub_Q1_shortline, prime_cpw_sub_Tee_shortline, second_cpw_sub_Tee_shortline, cut_FeedLeft_shortline, cut_FeedRight_shortline, cut_Readout_shortline, rect_pk_Q1, pocket_P1, pocket_P2, endcap_P1_in_1, endcap_P2_in_1)
boundaries and excitations:
  rlc_JJ_rect_Lj_1_rect_jj: Lumped RLC Objects=JJ_rect_Lj_1_rect_jj CurrentLine{(-0.785, -0.8, 0.0001) -> (-0.815, -0.8, 0.0001)} RLC_Type=Parallel Inductance=Lj
mesh:
  JunctionMesh: LengthBased Objects=JJ_rect_Lj_1_rect_jj MaxLength=5um
setups:
  EigenSetup: HfssEigen MinimumFrequency=2GHz NumModes=2 MaxDeltaFreq=0.3 ConvergeOnRealFreq=false MaximumPasses=16 MinimumPasses=3 MinimumConvergedPasses=2 PercentRefinement=25 BasisOrder=1
source amplitudes:
  #-10:1: 0 0
  #-10:2: 1 0
reports:
  Freq. vs. pass: re(Mode(1)), re(Mode(2)) vs Pass on EigenSetup : AdaptivePass [Lj=16nH]

design W240_Driven (HFSS, HFSS Modal Network, model units mm)
variables:
  Lj = 16nH
geometry:
  layer_1_datatype_0_plane [pec] = polyline(z=0.0001mm, xy in mm: (-2.5, -2) (2.5, -2) (2.5, 2) (-2.5, 2) (-2.5, -2), closed, covered)
  layer_1_datatype_0_plane.thicken(0.0002mm, both sides)
  layer_3_datatype_0_plane [silicon] = polyline(z=-0.25mm, xy in mm: (-2.5, -2) (2.5, -2) (2.5, 2) (-2.5, 2) (-2.5, -2), closed, covered)
  layer_3_datatype_0_plane.thicken(-0.5mm, both sides)
  vacuum_box [vacuum] = polyline(z=0mm, xy in mm: (-2.5, -2) (2.5, -2) (2.5, 2) (-2.5, 2) (-2.5, -2), closed, covered)
  vacuum_box.thicken(3mm, both sides)
  readout_wire_Q1 = polyline(z=0.0001mm, xy in mm: (-0.93, -0.5875) (-0.93, -0.5625) (-0.995, -0.48) (-0.995, -0.375))
  readout_wire_Q1_shortline [pec] = polyline((-0.935mm, -0.5875mm, 0.0001mm) (-0.925mm, -0.5875mm, 0.0001mm))
  readout_wire_Q1_shortline.sweep_along_path(readout_wire_Q1)
  readout_wire_Q1_shortline.thicken(0.0002mm, both sides)
  readout_wire_sub_Q1 = polyline(z=0.0001mm, xy in mm: (-0.93, -0.5875) (-0.93, -0.5625) (-0.995, -0.48) (-0.995, -0.375))
  readout_wire_sub_Q1_shortline = polyline((-0.941mm, -0.5875mm, 0.0001mm) (-0.919mm, -0.5875mm, 0.0001mm))
  readout_wire_sub_Q1_shortline.sweep_along_path(readout_wire_sub_Q1)
  readout_wire_sub_Q1_shortline.thicken(0.0002mm, both sides)
  prime_cpw_Tee = polyline((-0.25mm, 1mm, 0.0001mm) (0.25mm, 1mm, 0.0001mm))
  prime_cpw_Tee_shortline [pec] = polyline((-0.25mm, 1.005mm, 0.0001mm) (-0.25mm, 0.995mm, 0.0001mm))
  prime_cpw_Tee_shortline.sweep_along_path(prime_cpw_Tee)
  prime_cpw_Tee_shortline.thicken(0.0002mm, both sides)
  prime_cpw_sub_Tee = polyline((-0.25mm, 1mm, 0.0001mm) (0.25mm, 1mm, 0.0001mm))
  prime_cpw_sub_Tee_shortline = polyline((-0.25mm, 1.011mm, 0.0001mm) (-0.25mm, 0.989mm, 0.0001mm))
  prime_cpw_sub_Tee_shortline.sweep_along_path(prime_cpw_sub_Tee)
  prime_cpw_sub_Tee_shortline.thicken(0.0002mm, both sides)
  second_cpw_Tee = polyline(z=0.0001mm, xy in mm: (-0.125, 0.973) (0.125, 0.973) (0.125, 0.873))
  second_cpw_Tee.fillet(Vertices=second_cpw_Tee.vertex(at (0.125, 0.973, 0.0001)) Radius=0.025mm Setback=0mm)
  second_cpw_Tee_shortline [pec] = polyline((-0.125mm, 0.978mm, 0.0001mm) (-0.125mm, 0.968mm, 0.0001mm))
  second_cpw_Tee_shortline.sweep_along_path(second_cpw_Tee)
  second_cpw_Tee_shortline.thicken(0.0002mm, both sides)
  second_cpw_sub_Tee = polyline(z=0.0001mm, xy in mm: (-0.125, 0.973) (0.125, 0.973) (0.125, 0.873))
  second_cpw_sub_Tee.fillet(Vertices=second_cpw_sub_Tee.vertex(at (0.125, 0.973, 0.0001)) Radius=0.025mm Setback=0mm)
  second_cpw_sub_Tee_shortline = polyline((-0.125mm, 0.984mm, 0.0001mm) (-0.125mm, 0.962mm, 0.0001mm))
  second_cpw_sub_Tee_shortline.sweep_along_path(second_cpw_sub_Tee)
  second_cpw_sub_Tee_shortline.thicken(0.0002mm, both sides)
  trace_FeedLeft = polyline((-1.975mm, 1mm, 0.0001mm) (-0.25mm, 1mm, 0.0001mm))
  trace_FeedLeft_shortline [pec] = polyline((-1.975mm, 1.005mm, 0.0001mm) (-1.975mm, 0.995mm, 0.0001mm))
  trace_FeedLeft_shortline.sweep_along_path(trace_FeedLeft)
  trace_FeedLeft_shortline.thicken(0.0002mm, both sides)
  cut_FeedLeft = polyline((-1.975mm, 1mm, 0.0001mm) (-0.25mm, 1mm, 0.0001mm))
  cut_FeedLeft_shortline = polyline((-1.975mm, 1.011mm, 0.0001mm) (-1.975mm, 0.989mm, 0.0001mm))
  cut_FeedLeft_shortline.sweep_along_path(cut_FeedLeft)
  cut_FeedLeft_shortline.thicken(0.0002mm, both sides)
  trace_FeedRight = polyline((0.25mm, 1mm, 0.0001mm) (1.975mm, 1mm, 0.0001mm))
  trace_FeedRight_shortline [pec] = polyline((0.25mm, 1.005mm, 0.0001mm) (0.25mm, 0.995mm, 0.0001mm))
  trace_FeedRight_shortline.sweep_along_path(trace_FeedRight)
  trace_FeedRight_shortline.thicken(0.0002mm, both sides)
  cut_FeedRight = polyline((0.25mm, 1mm, 0.0001mm) (1.975mm, 1mm, 0.0001mm))
  cut_FeedRight_shortline = polyline((0.25mm, 1.011mm, 0.0001mm) (0.25mm, 0.989mm, 0.0001mm))
  cut_FeedRight_shortline.sweep_along_path(cut_FeedRight)
  cut_FeedRight_shortline.thicken(0.0002mm, both sides)
  trace_Readout = polyline(z=0.0001mm, xy in mm: (-0.995, -0.375) (-0.995, -0.06324778) (-0.845, -0.06324778) (-0.845, -0.38675222) (-0.695, -0.38675222) (-0.695, -0.06324778) (-0.545, -0.06324778) (-0.545, -0.38675222) (-0.395, -0.38675222) (-0.395, -0.06324778) (-0.245, -0.06324778) (-0.245, -0.38675222) (0.125, -0.38675222) (0.125, 0.873))
  trace_Readout.fillet(Vertices=trace_Readout.vertex(at (-0.995, -0.0632478, 0.0001)) Radius=0.06mm Setback=0mm)
  trace_Readout.fillet(Vertices=trace_Readout.vertex(at (-0.845, -0.0632478, 0.0001)) Radius=0.06mm Setback=0mm)
  trace_Readout.fillet(Vertices=trace_Readout.vertex(at (-0.845, -0.386752, 0.0001)) Radius=0.06mm Setback=0mm)
  trace_Readout.fillet(Vertices=trace_Readout.vertex(at (-0.695, -0.386752, 0.0001)) Radius=0.06mm Setback=0mm)
  trace_Readout.fillet(Vertices=trace_Readout.vertex(at (-0.695, -0.0632478, 0.0001)) Radius=0.06mm Setback=0mm)
  trace_Readout.fillet(Vertices=trace_Readout.vertex(at (-0.545, -0.0632478, 0.0001)) Radius=0.06mm Setback=0mm)
  trace_Readout.fillet(Vertices=trace_Readout.vertex(at (-0.545, -0.386752, 0.0001)) Radius=0.06mm Setback=0mm)
  trace_Readout.fillet(Vertices=trace_Readout.vertex(at (-0.395, -0.386752, 0.0001)) Radius=0.06mm Setback=0mm)
  trace_Readout.fillet(Vertices=trace_Readout.vertex(at (-0.395, -0.0632478, 0.0001)) Radius=0.06mm Setback=0mm)
  trace_Readout.fillet(Vertices=trace_Readout.vertex(at (-0.245, -0.0632478, 0.0001)) Radius=0.06mm Setback=0mm)
  trace_Readout.fillet(Vertices=trace_Readout.vertex(at (-0.245, -0.386752, 0.0001)) Radius=0.06mm Setback=0mm)
  trace_Readout.fillet(Vertices=trace_Readout.vertex(at (0.125, -0.386752, 0.0001)) Radius=0.06mm Setback=0mm)
  trace_Readout_shortline [pec] = polyline((-1mm, -0.375mm, 0.0001mm) (-0.99mm, -0.375mm, 0.0001mm))
  trace_Readout_shortline.sweep_along_path(trace_Readout)
  trace_Readout_shortline.thicken(0.0002mm, both sides)
  cut_Readout = polyline(z=0.0001mm, xy in mm: (-0.995, -0.375) (-0.995, -0.06324778) (-0.845, -0.06324778) (-0.845, -0.38675222) (-0.695, -0.38675222) (-0.695, -0.06324778) (-0.545, -0.06324778) (-0.545, -0.38675222) (-0.395, -0.38675222) (-0.395, -0.06324778) (-0.245, -0.06324778) (-0.245, -0.38675222) (0.125, -0.38675222) (0.125, 0.873))
  cut_Readout.fillet(Vertices=cut_Readout.vertex(at (-0.995, -0.0632478, 0.0001)) Radius=0.06mm Setback=0mm)
  cut_Readout.fillet(Vertices=cut_Readout.vertex(at (-0.845, -0.0632478, 0.0001)) Radius=0.06mm Setback=0mm)
  cut_Readout.fillet(Vertices=cut_Readout.vertex(at (-0.845, -0.386752, 0.0001)) Radius=0.06mm Setback=0mm)
  cut_Readout.fillet(Vertices=cut_Readout.vertex(at (-0.695, -0.386752, 0.0001)) Radius=0.06mm Setback=0mm)
  cut_Readout.fillet(Vertices=cut_Readout.vertex(at (-0.695, -0.0632478, 0.0001)) Radius=0.06mm Setback=0mm)
  cut_Readout.fillet(Vertices=cut_Readout.vertex(at (-0.545, -0.0632478, 0.0001)) Radius=0.06mm Setback=0mm)
  cut_Readout.fillet(Vertices=cut_Readout.vertex(at (-0.545, -0.386752, 0.0001)) Radius=0.06mm Setback=0mm)
  cut_Readout.fillet(Vertices=cut_Readout.vertex(at (-0.395, -0.386752, 0.0001)) Radius=0.06mm Setback=0mm)
  cut_Readout.fillet(Vertices=cut_Readout.vertex(at (-0.395, -0.0632478, 0.0001)) Radius=0.06mm Setback=0mm)
  cut_Readout.fillet(Vertices=cut_Readout.vertex(at (-0.245, -0.0632478, 0.0001)) Radius=0.06mm Setback=0mm)
  cut_Readout.fillet(Vertices=cut_Readout.vertex(at (-0.245, -0.386752, 0.0001)) Radius=0.06mm Setback=0mm)
  cut_Readout.fillet(Vertices=cut_Readout.vertex(at (0.125, -0.386752, 0.0001)) Radius=0.06mm Setback=0mm)
  cut_Readout_shortline = polyline((-1.006mm, -0.375mm, 0.0001mm) (-0.984mm, -0.375mm, 0.0001mm))
  cut_Readout_shortline.sweep_along_path(cut_Readout)
  cut_Readout_shortline.thicken(0.0002mm, both sides)
  pad_top_Q1 [pec] = polyline(z=0.0001mm, xy in mm: (-0.815, -1.0125) (-0.815, -0.5875) (-0.905, -0.5875) (-0.905, -1.0125) (-0.815, -1.0125), closed, covered)
  pad_top_Q1.thicken(0.0002mm, both sides)
  pad_bot_Q1 [pec] = polyline(z=0.0001mm, xy in mm: (-0.695, -1.0125) (-0.695, -0.5875) (-0.785, -0.5875) (-0.785, -1.0125) (-0.695, -1.0125), closed, covered)
  pad_bot_Q1.thicken(0.0002mm, both sides)
  rect_pk_Q1 = polyline(z=0.0001mm, xy in mm: (-0.475, -1.125) (-0.475, -0.475) (-1.125, -0.475) (-1.125, -1.125) (-0.475, -1.125), closed, covered)
  rect_pk_Q1.thicken(0.0002mm, both sides)
  readout_connector_pad_Q1 [pec] = polyline(z=0.0001mm, xy in mm: (-0.92, -0.8275) (-0.92, -0.5875) (-0.95, -0.5875) (-0.95, -0.8275) (-0.92, -0.8275), closed, covered)
  readout_connector_pad_Q1.thicken(0.0002mm, both sides)
  launch_pad_P1 [pec] = polyline(z=0.0001mm, xy in mm: (-2, 1.005) (-2.122, 1.04) (-2.202, 1.04) (-2.202, 0.96) (-2.122, 0.96) (-2, 0.995) (-1.975, 0.995) (-1.975, 1.005) (-2, 1.005), closed, covered)
  launch_pad_P1.thicken(0.0002mm, both sides)
  pocket_P1 = polyline(z=0.0001mm, xy in mm: (-2, 1.011) (-2.122, 1.098) (-2.26, 1.098) (-2.26, 0.902) (-2.122, 0.902) (-2, 0.989) (-1.975, 0.989) (-1.975, 1.011) (-2, 1.011), closed, covered)
  pocket_P1.thicken(0.0002mm, both sides)
  launch_pad_P2 [pec] = polyline(z=0.0001mm, xy in mm: (2, 0.995) (2.122, 0.96) (2.202, 0.96) (2.202, 1.04) (2.122, 1.04) (2, 1.005) (1.975, 1.005) (1.975, 0.995) (2, 0.995), closed, covered)
  launch_pad_P2.thicken(0.0002mm, both sides)
  pocket_P2 = polyline(z=0.0001mm, xy in mm: (2, 0.989) (2.122, 0.902) (2.26, 0.902) (2.26, 1.098) (2.122, 1.098) (2, 1.011) (1.975, 1.011) (1.975, 0.989) (2, 0.989), closed, covered)
  pocket_P2.thicken(0.0002mm, both sides)
  JJ_Lj_1_rect_jj_ = polyline((-0.785mm, -0.8mm, 0.0001mm) (-0.815mm, -0.8mm, 0.0001mm))
  JJ_rect_Lj_1_rect_jj = polyline((-0.785mm, -0.8mm, 0.0001mm) (-0.815mm, -0.8mm, 0.0001mm), section line width=0.02mm)
  port_endcap_P1_in_1 = polyline((-2.26mm, 1mm, 0.0001mm) (-2.202mm, 1mm, 0.0001mm), section line width=0.196mm)
  port_endcap_P1_in_1.thicken(0.0002mm, both sides)
  port_endcap_P2_in_1 = polyline((2.26mm, 1mm, 0.0001mm) (2.202mm, 1mm, 0.0001mm), section line width=0.196mm)
  port_endcap_P2_in_1.thicken(0.0002mm, both sides)
  Port_P1_in = polyline((-2.26mm, 1mm, 0.0001mm) (-2.202mm, 1mm, 0.0001mm), section line width=0.08mm)
  Port_P2_in = polyline((2.26mm, 1mm, 0.0001mm) (2.202mm, 1mm, 0.0001mm), section line width=0.08mm)
  layer_1_datatype_0_plane.subtract(readout_wire_sub_Q1_shortline, prime_cpw_sub_Tee_shortline, second_cpw_sub_Tee_shortline, cut_FeedLeft_shortline, cut_FeedRight_shortline, cut_Readout_shortline, rect_pk_Q1, pocket_P1, pocket_P2, port_endcap_P1_in_1, port_endcap_P2_in_1)
boundaries and excitations:
  rlc_JJ_rect_Lj_1_rect_jj: Lumped RLC Objects=JJ_rect_Lj_1_rect_jj CurrentLine{(-0.785, -0.8, 0.0001) -> (-0.815, -0.8, 0.0001)} RLC_Type=Parallel Inductance=Lj
  Port_P1_in: Lumped Port Objects=Port_P1_in LumpedPortType=Default Modes{Mode1{IntLine{(-2.26, 1, 0.0001) -> (-2.202, 1, 0.0001)} CharImp=Zpi RenormImp=50ohm}} Impedance=50ohm
  Port_P2_in: Lumped Port Objects=Port_P2_in LumpedPortType=Default Modes{Mode1{IntLine{(2.26, 1, 0.0001) -> (2.202, 1, 0.0001)} CharImp=Zpi RenormImp=50ohm}} Impedance=50ohm
mesh:
  JunctionMesh: LengthBased Objects=JJ_rect_Lj_1_rect_jj MaxLength=5um
  ReadoutMesh: LengthBased Objects=[trace_Readout_shortline, second_cpw_Tee_shortline] MaxLength=20um
setups:
  ReadoutSetup: HfssDriven Frequency=6.3897392GHz MaxDeltaS=0.01 MaximumPasses=16 MinimumPasses=3 MinimumConvergedPasses=2 PercentRefinement=25 BasisOrder=1 PortAccuracy=2 DrivenSolverType="Direct Solver"
    sweep Locate: 6.3297392GHz to 6.4497392GHz, 241 points; Type=Fast
    sweep Fine: 6.3737392GHz to 6.3937392GHz, 401 points; Type=Fast
source amplitudes:
  Port_P1_in:1: 1W 0deg
  Port_P2_in:1: 0W 0deg
